* NGSPICE file created from nor2b.ext - technology: sky130A
.subckt nor2b A B VDD VSS Y
X0 a_116_44# A VDD VDD sky130_fd_pr__pfet_01v8 ad=0.3765 pd=3.11 as=0.38366 ps=3.2116 w=1.255 l=0.15
X1 VDD a_116_44# a_1746_302# VDD sky130_fd_pr__pfet_01v8 ad=0.3057 pd=2.55904 as=0.3 ps=2.6 w=1 l=0.15
X2 VDD a_116_44# a_1746_302# VDD sky130_fd_pr__pfet_01v8 ad=0.3057 pd=2.55904 as=0.3 ps=2.6 w=1 l=0.15
X3 a_116_44# A VSS VSS sky130_fd_pr__nfet_01v8 ad=0.126 pd=1.44 as=0.12693 ps=1.32114 w=0.42 l=0.15
X4 Y B a_1746_302# VDD sky130_fd_pr__pfet_01v8 ad=0.31042 pd=2.624 as=0.3 ps=2.6 w=1 l=0.15
X5 a_116_44# A VSS VSS sky130_fd_pr__nfet_01v8 ad=0.126 pd=1.44 as=0.12693 ps=1.32114 w=0.42 l=0.15
X6 Y B a_1746_302# VDD sky130_fd_pr__pfet_01v8 ad=0.31042 pd=2.624 as=0.3 ps=2.6 w=1 l=0.15
X7 Y a_116_44# VSS VSS sky130_fd_pr__nfet_01v8 ad=0.18379 pd=1.78105 as=0.18133 ps=1.88734 w=0.6 l=0.15
X8 Y a_116_44# VSS VSS sky130_fd_pr__nfet_01v8 ad=0.18379 pd=1.78105 as=0.18133 ps=1.88734 w=0.6 l=0.15
X9 Y B a_1746_302# VDD sky130_fd_pr__pfet_01v8 ad=0.31042 pd=2.624 as=0.3 ps=2.6 w=1 l=0.15
X10 Y B a_1746_302# VDD sky130_fd_pr__pfet_01v8 ad=0.31042 pd=2.624 as=0.3 ps=2.6 w=1 l=0.15
X11 VDD a_116_44# a_1746_302# VDD sky130_fd_pr__pfet_01v8 ad=0.3057 pd=2.55904 as=0.3 ps=2.6 w=1 l=0.15
X12 a_116_44# A VSS VSS sky130_fd_pr__nfet_01v8 ad=0.126 pd=1.44 as=0.12693 ps=1.32114 w=0.42 l=0.15
X13 a_116_44# A VDD VDD sky130_fd_pr__pfet_01v8 ad=0.3765 pd=3.11 as=0.38366 ps=3.2116 w=1.255 l=0.15
X14 VDD a_116_44# a_1746_302# VDD sky130_fd_pr__pfet_01v8 ad=0.3057 pd=2.55904 as=0.3 ps=2.6 w=1 l=0.15
X15 Y B a_1746_302# VDD sky130_fd_pr__pfet_01v8 ad=0.31042 pd=2.624 as=0.3 ps=2.6 w=1 l=0.15
X16 VSS B Y VSS sky130_fd_pr__nfet_01v8 ad=0.21155 pd=2.2019 as=0.21442 ps=2.07789 w=0.7 l=0.15
X17 VDD a_116_44# a_1746_302# VDD sky130_fd_pr__pfet_01v8 ad=0.3057 pd=2.55904 as=0.3 ps=2.6 w=1 l=0.15
X18 a_116_44# A VDD VDD sky130_fd_pr__pfet_01v8 ad=0.3765 pd=3.11 as=0.38366 ps=3.2116 w=1.255 l=0.15
C0 B VDD 0.72649f
C1 a_116_44# VDD 2.02415f
C2 Y VDD 0.51095f
C3 a_1746_302# VDD 2.73663f
C4 a_116_44# B 0.00957f
C5 A VDD 0.47956f
C6 Y B 0.38548f
C7 a_1746_302# B 0.11896f
C8 Y a_116_44# 0.14199f
C9 a_116_44# a_1746_302# 0.14575f
C10 Y a_1746_302# 1.1427f
C11 A a_116_44# 0.20739f
C12 Y A 0
C13 A a_1746_302# 0
C14 Y VSS 2.71217f
C15 B VSS 1.35101f
C16 A VSS 0.75685f
C17 VDD VSS 8.45433f
C18 a_1746_302# VSS 0.51612f
C19 a_116_44# VSS 2.61355f
.ends nor2b
